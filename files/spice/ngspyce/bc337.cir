* BC337AP ZETEX Spice model Last revision 4/90 Medium Power
* ZTX Si 625mW 45V 800mA 100MHz pkg:TO-92 1,2,3
.MODEL QBC337AP NPN ( IS=3.94E-14 BF=175 VAF=109.4 IKF=0.8 ISE=7.4E-15
+ NE=1.3 BR=20.5 NR=0.974 VAR=14.25 IKR=0.1 ISC=3.16E-13 NC=1.2 RB=1.1
+ RE=0.1259 RC=0.0539 CJE=6.3E-11 TF=7.5E-10 CJC=1.58E-11 VJC=0.505
+ MJC=0.39 TR=8.5E-8 )
